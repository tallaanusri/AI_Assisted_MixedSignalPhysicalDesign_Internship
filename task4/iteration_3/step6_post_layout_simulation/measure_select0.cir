.control
  load results/select0_postlayout.raw
  print v(i0) v(out)
  meas tran trise TRIG v(i0) VAL=0.9 RISE=1 TARG v(out) VAL=0.9 RISE=1
  meas tran tfall TRIG v(i0) VAL=0.9 FALL=1 TARG v(out) VAL=0.9 FALL=1
  quit
.endc
