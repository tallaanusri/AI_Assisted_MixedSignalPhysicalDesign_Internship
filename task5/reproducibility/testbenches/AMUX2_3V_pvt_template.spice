*=============================================================
* Task 5 - AMUX2_3V PVT Characterization Testbench
*
* Parameters:
*   VDDVAL  = supply voltage
*   TEMPVAL = temperature
*   CORNER  = TT / SS / FF
*   SELVAL  = 0 / 1
*
* DUT:
*   I0 I1 select out VDD VSS
*=============================================================

.param VDDVAL=1.8
.param TEMPVAL=27

VDD VDD 0 {VDDVAL}
VSS VSS 0 0

* Select and input stimulus are generated by the
* automated characterization script.

* 20 fF output load
CLOAD out 0 20f

*-------------------------------------------------------------
* SKY130 model
*-------------------------------------------------------------
* SKY130 model library:
* The automated PVT script resolves sky130.lib.spice from PDK_ROOT.
* Do not hard-code a machine-specific PDK path in this template.
* Example resolved form:
* .lib "$PDK_ROOT/sky130A/libs.tech/ngspice/sky130.lib.spice" tt

.temp {TEMPVAL}

*-------------------------------------------------------------
* DUT
*-------------------------------------------------------------
* The automated script replaces this line with the
* verified Task 4 post-layout extracted subcircuit.
*
* XMUX I0 I1 select out VDD VSS AMUX2_3V_magic83_DRC0_select_fixed

.tran 1p 20n

.end
